* Daedalus 13 — series RL step (hand: v(2)=5*exp(-t/1ms))
Vin 1 0 DC 5
R1 1 2 1k
L1 2 0 1
.tran 10u 5m
.print tran v(2) i(L1)
.end

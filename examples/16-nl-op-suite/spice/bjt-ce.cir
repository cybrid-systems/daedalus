* Daedalus 16 — basic BJT CE bias
* Educational Ebers-Moll: IS=1e-15 BF=100 BR=1
Vcc 1 0 DC 5
Rc 1 2 1k
Vin 4 0 DC 1.2
Rb 4 3 20k
Q1 2 3 0 Qedu
.model Qedu NPN(IS=1e-15 BF=100 BR=1)
.options tnom=28.555 temp=28.555 gmin=1e-12
.control
op
print v(1) v(2) v(3) v(4) i(Vcc) i(Vin)
.endc
.end

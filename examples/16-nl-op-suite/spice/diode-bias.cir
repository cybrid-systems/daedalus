* Daedalus 16 — single diode bias (V=0.7 across D)
* Educational Shockley: IS=1e-14 N=1, T so Vt≈26 mV
Vin 1 0 DC 0.7
D1 1 0 Dedu
.model Dedu D(IS=1e-14 N=1)
.options tnom=28.555 temp=28.555 gmin=1e-12
.control
op
print v(1) i(Vin)
.endc
.end

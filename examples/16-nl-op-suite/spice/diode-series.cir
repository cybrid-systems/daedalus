* Daedalus 16 — series diode + R
Vin 1 0 DC 5
R1 1 2 1k
D1 2 0 Dedu
.model Dedu D(IS=1e-14 N=1)
.options tnom=28.555 temp=28.555 gmin=1e-12
.control
op
print v(1) v(2) i(Vin)
.endc
.end

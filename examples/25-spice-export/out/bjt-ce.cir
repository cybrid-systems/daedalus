* Daedalus spice export: bjt-ce
* subset: R C L V I D(Shockley) Q(NPN Ebers-Moll) M(NMOS Level-1) E G F H
* daed-temp=27 daed-tnom=27
* Cgs/Cgd MOSFET parasitics omitted (Daedalus .tran only)
vcc 1 0 DC 5
rc 1 2 1000
vin 4 0 DC 1.2
rb 4 3 20000
q1 2 3 0 Qq1
.model Qq1 NPN(IS=1e-15 BF=100 BR=1)
.options tnom=28.555 temp=28.555 gmin=1e-12
.control
op
print v(1) v(2) v(3) v(4)
print i(vcc)
print i(vin)
.endc
.end
